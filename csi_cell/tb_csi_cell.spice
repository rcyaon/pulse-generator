** sch_path: /headless/pulse-generator/csi_cell/sim/tb_csi_cell.sch
**.subckt tb_csi_cell
x1 net1 net2 csi_cell
I0 net1 GND 5u
V1 net2 GND v
**** begin user architecture code

.tran 0.1n 400n

.step param Ibias 1u 20u 1u
.tran 0.1n 400n

**** end user architecture code
**.ends

* expanding   symbol:  /headless/pulse-generator/csi_cell/csi_cell.sym # of pins=2
** sym_path: /headless/pulse-generator/csi_cell/csi_cell.sym
** sch_path: /headless/pulse-generator/csi_cell/csi_cell.sch
.subckt csi_cell Ibias Vin
*.ipin Vin
*.ipin Ibias
XM2 Vout Vin net2 GND sky130_fd_pr__nfet_01v8 L=0.15 W=1 nf=1 ad=0.29 as=0.29 pd=2.58 ps=2.58 nrd=0.29 nrs=0.29 sa=0 sb=0 sd=0
+ mult=1 m=1
XM3 net2 Ibias GND GND sky130_fd_pr__nfet_01v8 L=0.5 W=1 nf=1 ad=0.29 as=0.29 pd=2.58 ps=2.58 nrd=0.29 nrs=0.29 sa=0 sb=0 sd=0
+ mult=1 m=1
XM4 Vout Vin net1 VDD sky130_fd_pr__pfet_01v8 L=0.15 W=2 nf=1 ad=0.58 as=0.58 pd=4.58 ps=4.58 nrd=0.145 nrs=0.145 sa=0 sb=0 sd=0
+ mult=1 m=1
XM5 net1 Ibias VDD VDD sky130_fd_pr__pfet_01v8 L=0.5 W=1 nf=1 ad=0.29 as=0.29 pd=2.58 ps=2.58 nrd=0.29 nrs=0.29 sa=0 sb=0 sd=0
+ mult=1 m=1
V1 VDD GND 1.8
.ends

.GLOBAL GND
.end
